# Ansys Electronics Desktop project, version 2018.2
materials:
  vacuum: permittivity=1
  pec: conductivity=1e+30

design HFSSDesign1 (HFSS, DrivenModal, model units mm)
variables:
  a1 = 231.1mm
  b1 = 180.6mm
  L = 282mm
  a = 40.386mm
  b = 20.193mm
  lrec = 38.79mm
  lf = 25.86mm
  rp = 1.3mm
  lp = 11.1mm
  rout = 3mm
geometry:
  Rectangle1 = rectangle(corner=(-a1/2, -b1/2, L), x_size=a1, y_size=b1)
  Rectangle2 = rectangle(corner=(-a/2, -b/2, 0mm), x_size=a, y_size=b)
  Rectangle1.connect(Rectangle2)
  Box1 = box(corner=(-a/2, -b/2, 0mm), size=(a, b, -lrec))
  Rectangle1_ObjectFromFace1 = object_from(Rectangle1.face(#31))
  Rectangle1_ObjectFromFace2 = object_from(Rectangle1.face(#32))
  Rectangle1_ObjectFromFace3 = object_from(Rectangle1.face(#33))
  Rectangle1_ObjectFromFace4 = object_from(Rectangle1.face(#30))
  Rectangle1.delete()
  Box1_ObjectFromFace1 = object_from(Box1.face(+x))
  Box1_ObjectFromFace2 = object_from(Box1.face(+y))
  Box1_ObjectFromFace3 = object_from(Box1.face(-x))
  Box1_ObjectFromFace4 = object_from(Box1.face(-y))
  Box1_ObjectFromFace5 = object_from(Box1.face(-z))
  Box1.delete()
  Cylinder1 [pec] = cylinder(axis=Y, base_centre=(0mm, b/2, -lf), radius=rp, height=-lp)
  Circle1 = circle(normal=Y, centre=(0mm, b/2, -lf), radius=rout)
  Circle1_1 = Circle1.copy()
  Box1_ObjectFromFace2.subtract(Circle1_1)
  Box2 [vacuum] = box(corner=(-200mm, -200mm, -200mm), size=(400mm, 400mm, 600mm))
boundaries and excitations:
  PerfE1: Perfect E Objects=[Box1_ObjectFromFace1..Box1_ObjectFromFace5, Rectangle1_ObjectFromFace1..Rectangle1_ObjectFromFace4]
  Rad1: Radiation Objects=Box2
  1: Lumped Port Faces=Circle1.face(at (0, 10.0965, -25.86)) Modes{Mode1{IntLine{Cylinder1.vertex(2 of 2) -> Circle1.vertex(1 of 1)} CharImp=Zpi RenormImp=50ohm}} Impedance=50ohm
setups:
  Setup1: HfssDriven AdaptMultipleFreqs MultipleAdaptiveFreqsSetup{4.64GHz(0.1) 5.8GHz(0.1) 7.04GHz(0.1)} MaximumPasses=10 MinimumPasses=1 MinimumConvergedPasses=1 PercentRefinement=30 BasisOrder=1 PortAccuracy=2
    sweep Sweep: 4GHz to 8GHz step 0.02GHz; Type=Fast SaveFields
source amplitudes:
  1:1: 1W 0deg
optimetrics:
  ParametricSetup1: Parametric Sim._Setups=[Setup1]
    sweep lp: LIN 10.1mm 15.1mm 1mm
radiation setups:
  Infinite Sphere1: Infinite Sphere Theta=-180deg..180deg step 2deg Phi=0deg..360deg step 2deg
reports:
  S Parameter Plot 1: dB(S(1,1)) vs Freq on Setup1 : Sweep; markers m1 at 4.64GHz, m2 at 7.04GHz
  S Parameter Plot 3: dB(S(1,1)) vs Freq on Setup1 : Sweep [lp=all]; markers m1 at 4.64GHz, m2 at 7.05GHz
  Gain Plot 1: dB(GainTotal) vs Theta on Setup1 : LastAdaptive, Infinite Sphere1 [Phi=0deg,180deg Freq=5.8GHz lp=10.1mm]
  Gain Plot 2: dB(GainTotal) vs Theta on Setup1 : LastAdaptive, Infinite Sphere1 [Phi=0deg,180deg Freq=4.64GHz lp=11.1mm]
  Gain Plot 3: dB(GainTotal) vs Theta on Setup1 : LastAdaptive, Infinite Sphere1 [Phi=0deg,180deg Freq=5.8GHz lp=11.1mm]
  Gain Plot 4: dB(GainTotal) vs Theta on Setup1 : LastAdaptive, Infinite Sphere1 [Phi=0deg,90deg Freq=7.04GHz lp=11.1mm]
  Gain Plot 6: dB(GainTotal) vs Theta on Setup1 : LastAdaptive, Infinite Sphere1 [Phi=0deg,90deg Freq=7.04GHz lp=11.1mm]; markers m1 at 0deg, m2 at -10deg
  Gain Plot 10: dB(GainTotal) vs Theta on Setup1 : LastAdaptive, Infinite Sphere1 [Phi=0deg,180deg Freq=7.04GHz lp=11.1mm]
  Gain Plot 11: dB(GainTotal) vs Phi, Theta on Setup1 : LastAdaptive, Infinite Sphere1 [Freq=4.64GHz lp=11.1mm]
  Gain Plot 12: dB(GainTotal) vs Phi, Theta on Setup1 : LastAdaptive, Infinite Sphere1 [Freq=5.8GHz lp=11.1mm]
  Gain Plot 13: dB(GainTotal) vs Phi, Theta on Setup1 : LastAdaptive, Infinite Sphere1 [Freq=7.04GHz lp=11.1mm]
  Gain Plot 14: dB(GainTotal) vs Freq on Setup1 : LastAdaptive, Infinite Sphere1 [Phi=90deg Theta=0deg lp=11.1mm]; markers m1 at 5.8GHz
  Gain Plot 15: dB(GainTotal) vs Theta on Setup1 : LastAdaptive, Infinite Sphere1 [Phi=0deg,90deg Freq=5.8GHz lp=11.1mm]
  Gain Plot 16: dB(GainTotal) vs Theta on Setup1 : LastAdaptive, Infinite Sphere1 [Phi=0deg,90deg Freq=4.64GHz lp=11.1mm]
